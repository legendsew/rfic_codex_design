unless(boundp('RFIC_session_active) RFIC_session_active=nil)
unless(boundp('RFIC_session_generation) RFIC_session_generation=0)
unless(boundp('RFIC_poll_pending) RFIC_poll_pending=nil)
unless(boundp('RFIC_command_busy) RFIC_command_busy=nil)

procedure(RFIC_write_command_status(status_path status)
    let((port)
        port=outfile(status_path)
        unless(port error("RFIC: cannot write command status"))
        fprintf(port "%d" status)
        close(port)
        t))

procedure(RFIC_execute_command(command status_path completion_delay)
    let((result status)
        result=errset(apply(command nil) t)
        status=if(result 0 1)
        if(completion_delay > 0 && status == 0 then
            hiRegTimer(sprintf(nil "RFIC_write_command_status(%L %d)" status_path status) completion_delay)
        else
            RFIC_write_command_status(status_path status))
        result))

procedure(RFIC_schedule_poll()
    when(RFIC_session_active && !RFIC_poll_pending
        RFIC_poll_pending=t
        hiRegTimer(sprintf(nil "RFIC_poll_commands(%d)" RFIC_session_generation) 1)))

procedure(RFIC_poll_commands(@optional generation)
    when(generation && generation == RFIC_session_generation && RFIC_session_active
        RFIC_poll_pending=nil
        when(!RFIC_command_busy && isFile(RFIC_command_path)
            let((running_path result)
                RFIC_command_busy=t
                running_path=strcat(RFIC_command_path ".running")
                if(renameFile(RFIC_command_path running_path) then
                    result=errset(load(running_path) t)
                    deleteFile(running_path)
                    unless(result RFIC_write_command_status(RFIC_status_path 1))
                else
                    RFIC_write_command_status(RFIC_status_path 1))
                RFIC_command_busy=nil))
        RFIC_schedule_poll()))

procedure(RFIC_start_session(command_path status_path)
    RFIC_command_path=command_path
    RFIC_status_path=status_path
    unless(RFIC_session_active
        RFIC_session_active=t
        RFIC_session_generation=RFIC_session_generation+1
        RFIC_poll_pending=t
        hiRegTimer(sprintf(nil "RFIC_poll_commands(%d)" RFIC_session_generation) 10))
    unless(getd('show_EMX_gui)
        unless(boundp('RFIC_emx_config_path) error("RFIC: EMX interface path is not configured"))
        load(RFIC_emx_config_path))
    RFIC_schedule_poll()
    t)

procedure(open_wizard()
    _Passive_tool_APP_FieldFormCB()
    )

procedure(create_lib(lib_name lib_path tech)
    unless(ddGetObj(lib_name)
        unless(ddGetObj(tech) error("RFIC: PDK library %s is not registered" tech))
        unless(ddCreateLib(lib_name lib_path) error("RFIC: Cannot create design library %s" lib_name))
        techBindTechFile(ddGetObj(lib_name) tech)
    )
)

procedure(RFIC_register_symbol_lib(lib_name lib_path)
    unless(ddGetObj(lib_name)
        unless(isDir(lib_path) error("RFIC: Symbol library directory not found: %s" lib_path))
        unless(ddCreateLib(lib_name lib_path) error("RFIC: Cannot register symbol library %s" lib_name))
    )
)

procedure(fill_wizard(value tech mos_name lib_name Generation_Code cell_name model_path setup_file_path)
    if(value == 4 then
        hiGetCurrentForm()->Passive_tool_APP_Field->value = 4
        Active_Field_CallBack_Load()
        hiGetCurrentForm()->Passive_tool_APP_Field->page4->t_sourceLibComb->value="CSPA"
        hiGetCurrentForm()->Passive_tool_APP_Field->page4->t_sourceCellComb->value="CSPA_lvt4t"
        hiGetCurrentForm()->Passive_tool_APP_Field->page4->t_destnmos4tLibComb->value=tech
        hiGetCurrentForm()->Passive_tool_APP_Field->page4->t_destnmos4tCellComb->value=mos_name
        hiGetCurrentForm()->Passive_tool_APP_Field->page4->model_pathField->value=model_path
        hiGetCurrentForm()->Passive_tool_APP_Field->page4->VariablesSetupField->value= Generation_Code
        ApplyPress(RFIC_PDKToolForm)
        )
    if(value == 3 then
        hiGetCurrentForm()->Passive_tool_APP_Field->value = 3
        hiGetCurrentForm()->Passive_tool_APP_Field->page3->WEB_CODE_setup_pathField->value = setup_file_path
        _setupLoadField()
        hiGetCurrentForm()->Passive_tool_APP_Field->page3->WEB_CODE_Excelweb_outputField->value= Generation_Code
        hiGetCurrentForm()->Passive_tool_APP_Field->page3->WEB_CODE_ExcelLibField->value=lib_name
        hiGetCurrentForm()->Passive_tool_APP_Field->page3->WEB_CODE_ExcelCell_nameField->value= cell_name
        _WEB_CODE_ExcelApplyFieldCB()
        )
    )

procedure(close_log_window()
    system("xdotool search --name \"Stream in translation complete\" key --window %@ Escape")
    )

procedure(RFIC_confirm_parametric_points(checks)
    when(boundp('RFIC_parametric_confirmation_active) && RFIC_parametric_confirmation_active
        system("xdotool search --onlyvisible --name '^Too Many Points[?]$' key --window %@ Return >/dev/null 2>&1")
        if(checks > 0 then
            hiRegTimer(sprintf(nil "RFIC_confirm_parametric_points(%d)" checks-1) 2)
        else
            RFIC_parametric_confirmation_active=nil))
    t)

procedure(RFIC_close_confirmation_windows(@optional (checks 0))
    when(checks == 0 || (boundp('RFIC_close_confirmations_active) && RFIC_close_confirmations_active)
        when(boundp('apaCloseWindowDBox) &&
            system("xdotool search --onlyvisible --name '^Close$' >/dev/null 2>&1") == 0
            hiDBoxOK(apaCloseWindowDBox))
        when(boundp('sevblockingDialogBox) &&
            system("xdotool search --onlyvisible --name '^Save State Query$' >/dev/null 2>&1") == 0
            hiDBoxOK(sevblockingDialogBox))
        when(checks > 0 && RFIC_close_confirmations_active
            hiRegTimer(sprintf(nil "RFIC_close_confirmation_windows(%d)" checks-1) 2)))
    t)

procedure(BBoxRightOfX(bBox xLimit)
    let((ll lx)
        ll = car(bBox)
        lx = car(ll)
        lx >= xLimit
        )
    )

procedure(RFIC_Delete(libName cellName xLimit)
    let((cv deleteInstList deleteShapeList deleteNetList)

        cv = dbOpenCellViewByType(libName cellName "schematic" "" "a")

        deleteInstList = nil
        deleteShapeList = nil
        deleteNetList = nil

        ;1.删除所有无源instance
        foreach(inst cv~>instances
            when(
                inst~>bBox &&
                car(car(inst~>bBox)) >= xLimit

                deleteInstList = cons(inst deleteInstList)
            )
        )

        foreach(inst deleteInstList
            errset(
                dbDeleteObject(inst)
                t
            )
        )

        ; 2. 删除 x >= xLimit 的 shape / wire / label / ellipse
        foreach(fig cv~>shapes
            when(fig~>bBox && BBoxRightOfX(fig~>bBox xLimit)
                deleteShapeList = cons(fig deleteShapeList)
            )
        )
        foreach(fig deleteShapeList
            errset(dbDeleteObject(fig) t)
        )
        schCheck(cv)
        ; 3. 删除已经空掉的 net
        foreach(net cv~>nets
            when(length(net~>instTerms) == 0 &&
                length(net~>terms) == 0 &&
                length(net~>figs) == 0
                deleteNetList = cons(net deleteNetList)
            )
        )

        foreach(net deleteNetList
            errset(dbDeleteObject(net) t)
        )

        schCheck(cv)
        dbSave(cv)
        dbClose(cv)
        )
    )

procedure(copy_schematic(cell_name @optional (lib_name "tsmcN65"))
    let((cv sourceCellViewID)
        sourceCellViewID = dbOpenCellViewByType("CSPA" "CSPA_lvt4t" "schematic" "" "r")
        cv = dbCopyCellView(
            sourceCellViewID
            lib_name
            cell_name
            "schematic"
            nil
            nil
            t
            )
        dbClose(sourceCellViewID)
        dbSave(cv)
        dbClose(cv)
        )
    )

procedure(Createwire(cv wirelist)
    schCreateWire(
        cv
        "draw"
        "full"
        wirelist
        0.0625
        0.0625
        0.0
        )
    )

procedure(place_PA_instance_and_wire(cv)
    let((ind_master res_master)
        ind_master = dbOpenCellViewByType("analogLib" "ind" "symbol" "" "r")
        res_master = dbOpenCellViewByType("analogLib" "res" "symbol" "" "r")
        schCreateInst(
            cv
            ind_master
            "L1"
            -0.875:3.5
            "R90"
            )
        schCreateInst(
            cv
            ind_master
            "L2"
            2.375:3.5
            "R90"
            )
        schCreateInst(
            cv
            res_master
            "R1"
            -0.4375:0
            "R90"
            )
        schCreateInst(
            cv
            res_master
            "R2"
            2.1875:0
            "R90"
            )
        Createwire(cv list(-0.5:3.5 2.375:3.5))
        Createwire(cv list(-0.0625:0 2.1875:0))
        schCreateWireLabel(
            cv
            nil
            1:3.5
            "vdda_"
            "centerCenter"
            "R0"
            "stick"
            0.0625
            nil
            )
        schCreateWireLabel(
            cv
            nil
            1:0
            "bias"
            "centerCenter"
            "R0"
            "stick"
            0.0625
            nil
            )
        schCheck(cv)
        dbSave(cv)
        ;dbClose(cv)
        )
    )

procedure(edit_property(cv)
    let((R1 R2 L1 L2 M1 M2 M3 M4)
        R1 = car(setof(inst cv~>instances inst~>name == "R1"))
        R2 = car(setof(inst cv~>instances inst~>name == "R2"))
        L1 = car(setof(inst cv~>instances inst~>name == "L1"))
        L2 = car(setof(inst cv~>instances inst~>name == "L2"))
        M1 = car(setof(inst cv~>instances inst~>name == "M1"))
        M2 = car(setof(inst cv~>instances inst~>name == "M2"))
        M3 = car(setof(inst cv~>instances inst~>name == "M3"))
        M4 = car(setof(inst cv~>instances inst~>name == "M4"))
        dbReplaceProp(R1 "r" "string" "R")
        dbReplaceProp(R2 "r" "string" "R")
        dbReplaceProp(L1 "l" "string" "L")
        dbReplaceProp(L2 "l" "string" "L")
        foreach(inst list(M1 M3)
            dbReplaceProp(inst "w" "string" "1u")
            dbReplaceProp(inst "fingers" "string" "NoF")
            dbReplaceProp(inst "simM" "string" "Mul")
            dbReplaceProp(inst "totalM" "string" "NoF*Mul")
            dbReplaceProp(inst "wf" "string" "1e-06*NoF")
            dbReplaceProp(inst "nrd" "string" "(NoF-int(NoF/2)*2)*(1e-07*1e-07/(1e-07+1e-07*(NoF-1))/1e-06)+(NoF+1-int((NoF+1)/2)*2)*(1e-07/NoF/1e-06)")
            dbReplaceProp(inst "nrs" "string" "(NoF-int(NoF/2)*2)*(1e-07*1e-07/(1e-07+1e-07*(NoF-1))/1e-06)+(NoF+1-int((NoF+1)/2)*2)*(1e-07*1e-07*1e-07/(1e-07*1e-07*(NoF-2)+1e-07*(1e-07+1e-07))/1e-06)")
            dbReplaceProp(inst "pd" "string" "(NoF-int(NoF/2)*2)*((1.75e-07+((NoF-1)*2e-07)/2+0)*2+(NoF+1)*1e-06)+(NoF+1-int((NoF+1)/2)*2)*(((NoF/2)*2e-07)*2+NoF*1e-06)")
            dbReplaceProp(inst "ps" "string" "(NoF-int(NoF/2)*2)*((1.75e-07+((NoF-1)*2e-07)/2+0)*2+(NoF+1)*1e-06)+(NoF+1-int((NoF+1)/2)*2)*((1.75e-07+1.75e-07+(NoF/2-1)*2e-07+0+0)*2+(NoF+2)*1e-06)")
            dbReplaceProp(inst "ad" "string" "((NoF-int(NoF/2)*2)*(1.75e-07+((NoF-1)*2e-07)/2+0)+(NoF+1-int((NoF+1)/2)*2)*((NoF/2)*2e-07))*1e-06")
            dbReplaceProp(inst "as" "string" "((NoF-int(NoF/2)*2)*(1.75e-07+((NoF-1)*2e-07)/2+0)+(NoF+1-int((NoF+1)/2)*2)*(1.75e-07+1.75e-07+(NoF/2-1)*2e-07+0+0))*1e-06")
            )
        foreach(inst list(M2 M4)
            dbReplaceProp(inst "w" "string" "1u")
            dbReplaceProp(inst "fingers" "string" "NoF2")
            dbReplaceProp(inst "simM" "string" "Mul2")
            dbReplaceProp(inst "totalM" "string" "NoF2*Mul2")
            dbReplaceProp(inst "wf" "string" "1e-06*NoF2")
            dbReplaceProp(inst "nrd" "string" "(NoF2-int(NoF2/2)*2)*(1e-07*1e-07/(1e-07+1e-07*(NoF2-1))/1e-06)+(NoF2+1-int((NoF2+1)/2)*2)*(1e-07/NoF2/1e-06)")
            dbReplaceProp(inst "nrs" "string" "(NoF2-int(NoF2/2)*2)*(1e-07*1e-07/(1e-07+1e-07*(NoF2-1))/1e-06)+(NoF2+1-int((NoF2+1)/2)*2)*(1e-07*1e-07*1e-07/(1e-07*1e-07*(NoF2-2)+1e-07*(1e-07+1e-07))/1e-06)")
            dbReplaceProp(inst "pd" "string" "(NoF2-int(NoF2/2)*2)*((1.75e-07+((NoF2-1)*2e-07)/2+0)*2+(NoF2+1)*1e-06)+(NoF2+1-int((NoF2+1)/2)*2)*(((NoF2/2)*2e-07)*2+NoF2*1e-06)")
            dbReplaceProp(inst "ps" "string" "(NoF2-int(NoF2/2)*2)*((1.75e-07+((NoF2-1)*2e-07)/2+0)*2+(NoF2+1)*1e-06)+(NoF2+1-int((NoF2+1)/2)*2)*((1.75e-07+1.75e-07+(NoF2/2-1)*2e-07+0+0)*2+(NoF2+2)*1e-06)")
            dbReplaceProp(inst "ad" "string" "((NoF2-int(NoF2/2)*2)*(1.75e-07+((NoF2-1)*2e-07)/2+0)+(NoF2+1-int((NoF2+1)/2)*2)*((NoF2/2)*2e-07))*1e-06")
            dbReplaceProp(inst "as" "string" "((NoF2-int(NoF2/2)*2)*(1.75e-07+((NoF2-1)*2e-07)/2+0)+(NoF2+1-int((NoF2+1)/2)*2)*(1.75e-07+1.75e-07+(NoF2/2-1)*2e-07+0+0))*1e-06")
            )
        schCheck(cv)
        dbSave(cv)
        ; dbClose(cv) ; Keep cv open for network placement and testbench creation.
        )
    )

procedure(place_in_transformer(cv x y @optional (symbol_lib "tsmcN65"))
    let((nport_master nport port_master port)
        nport_master = dbOpenCellViewByType(symbol_lib "inport_symbol" "symbol" "" "r")
        port_master = dbOpenCellViewByType("analogLib" "port" "symbol" "" "r")
        schCreateInst(
            cv
            nport_master
            "in_net"
            x:y
            "R0"
            )
        schCreateInst(
            cv
            port_master
            "PORT0"
            (x+2):y
            "R0"
            )
        nport = car(setof(inst cv~>instances inst~>name == "in_net"))
        dbReplaceProp(nport "Cp" "string" "Cp_in")
        dbReplaceProp(nport "Cs" "string" "Cs_in")
        dbReplaceProp(nport "s4p_path" "string" "s4p_path_in")
        Createwire(cv list((x-0.125):(y-0.1875) (x+0.0625):(y-0.1875)))
        Createwire(cv list((x+0.9375):y (x+1.125):y))
        Createwire(cv list((x+0.9375):(y-0.375) (x+1.125):(y-0.375)))
        Createwire(cv list((x+2):y (x+2):(y+0.25)))
        Createwire(cv list((x+2):(y-0.5) (x+2):(y-0.75)))
        schCreateWireLabel(
            cv
            nil
            (x-0.125):(y-0.1875)
            "IN"
            "centerCenter"
            "R0"
            "stick"
            0.0625
            nil
            )
        schCreateWireLabel(
            cv
            nil
            (x+1.125):y
            "inp"
            "centerCenter"
            "R0"
            "stick"
            0.0625
            nil
            )
        schCreateWireLabel(
            cv
            nil
            (x+1.125):(y-0.375)
            "inm"
            "centerCenter"
            "R0"
            "stick"
            0.0625
            nil
            )
        schCreateWireLabel(
            cv
            nil
            (x+2):(y+0.25)
            "IN"
            "centerCenter"
            "R90"
            "stick"
            0.0625
            nil
            )
        schCreateWireLabel(
            cv
            nil
            (x+2):(y-0.75)
            "vssa"
            "centerCenter"
            "R90"
            "stick"
            0.0625
            nil
            )
        port = car(setof(inst cv~>instances inst~>name == "PORT0"))
        dbReplaceProp(port "freq" "string" "Freq")
        dbReplaceProp(port "vaDBm" "string" "pin")
        schCheck(cv)
        dbSave(cv)
        ; dbClose由Virtuoso退出时统一处理
        )
    )

procedure(place_out_transformer(cv x y @optional (symbol_lib "tsmcN65"))
    let((nport_master nport port_master)
        nport_master = dbOpenCellViewByType(symbol_lib "outport_symbol" "symbol" "" "r")
        port_master = dbOpenCellViewByType("analogLib" "port" "symbol" "" "r")
        schCreateInst(
            cv
            nport_master
            "out_net"
            x:y
            "R0"
            )
        schCreateInst(
            cv
            port_master
            "PORT1"
            (x+2):y
            "R0"
            )
        nport = car(setof(inst cv~>instances inst~>name == "out_net"))
        dbReplaceProp(nport "Cp" "string" "Cp_out")
        dbReplaceProp(nport "Cs" "string" "Cs_out")
        dbReplaceProp(nport "s4p_path" "string" "s4p_path_out")
        Createwire(cv list((x-0.125):(y+0.25) (x+0.0625):(y+0.25)))
        Createwire(cv list((x-0.125):(y-0.125) (x+0.0625):(y-0.125)))
        Createwire(cv list((x+0.9375):(y+0.0625) (x+1.125):(y+0.0625)))
        Createwire(cv list((x+2):y (x+2):(y+0.25)))
        Createwire(cv list((x+2):(y-0.5) (x+2):(y-0.75)))
        schCreateWireLabel(
            cv
            nil
            (x-0.125):(y+0.25)
            "outp"
            "centerCenter"
            "R0"
            "stick"
            0.0625
            nil
            )
        schCreateWireLabel(
            cv
            nil
            (x-0.125):(y-0.125)
            "outm"
            "centerCenter"
            "R0"
            "stick"
            0.0625
            nil
            )
        schCreateWireLabel(
            cv
            nil
            (x+1.125):(y+0.0625)
            "OUT"
            "centerCenter"
            "R0"
            "stick"
            0.0625
            nil
            )
        schCreateWireLabel(
            cv
            nil
            (x+2):(y+0.25)
            "OUT"
            "centerCenter"
            "R90"
            "stick"
            0.0625
            nil
            )
        schCreateWireLabel(
            cv
            nil
            (x+2):(y-0.75)
            "vssa"
            "centerCenter"
            "R90"
            "stick"
            0.0625
            nil
            )
        schCheck(cv)
        dbSave(cv)
        ; dbClose由Virtuoso退出时统一处理
        )
    )

procedure(generate_V(cv)
    let((vdc_master gnd_master x vdc)
        port_master = dbOpenCellViewByType("analogLib" "port" "symbol" "" "r")
        vdc_master = dbOpenCellViewByType("analogLib" "vdc" "symbol" "" "r")
        gnd_master = dbOpenCellViewByType("analogLib" "gnd" "symbol" "" "r")
        x = -0.5
        foreach(V list("Vbias" "Vdd" "0")
            schCreateInst(
                cv
                vdc_master
                V
                x:5
                "R0"
                )
            vdc = car(setof(inst cv~>instances inst~>name == V))
            dbReplaceProp(vdc "vdc" "string" V)
            Createwire(cv list(x:5 x:5.25))
            case(V
                ("Vbias"
                    schCreateWireLabel(
                        cv
                        nil
                        x:5.25
                        "bias"
                        "centerCenter"
                        "R90"
                        "stick"
                        0.0625
                        nil
                        )
                    )
                ("Vdd"
                    schCreateWireLabel(
                        cv
                        nil
                        x:5.25
                        "vdda_"
                        "centerCenter"
                        "R90"
                        "stick"
                        0.0625
                        nil
                        )
                    )
                ("0"
                    schCreateWireLabel(
                        cv
                        nil
                        x:5.25
                        "vssa"
                        "centerCenter"
                        "R90"
                        "stick"
                        0.0625
                        nil
                        )
                    )
                )
            x = x+0.5
            )
        Createwire(cv list(-0.5:4.625 0.5:4.625))
        schCreateInst(
            cv
            gnd_master
            ""
            0.5:4.625
            "R0"
            )
        schCheck(cv)
        dbSave(cv)
        dbClose(cv)
        )
    )

procedure(measure_Zin(cv)
    let((port_master x)
        port_master = dbOpenCellViewByType("analogLib" "port" "symbol" "" "r")
        x = 4
        foreach(port_name list("PORT1" "PORT2")
            schCreateInst(
                cv
                port_master
                port_name
                x:4
                "R0"
                )
            Createwire(cv list(x:4 x:4.25))
            Createwire(cv list(x:3.25 x:3.5))
            schCreateWireLabel(
                cv
                nil
                x:3.25
                "vssa"
                "centerCenter"
                "R90"
                "stick"
                0.0625
                nil
                )
            if(port_name == "PORT1" then
                schCreateWireLabel(
                    cv
                    nil
                    x:4.25
                    "inp"
                    "centerCenter"
                    "R90"
                    "stick"
                    0.0625
                    nil
                    )
                )
            if(port_name == "PORT2" then
                schCreateWireLabel(
                    cv
                    nil
                    x:4.25
                    "inm"
                    "centerCenter"
                    "R90"
                    "stick"
                    0.0625
                    nil
                    )
                )
            x = x+0.5
            )
        schCheck(cv)
        dbSave(cv)
        ;dbClose(cv)
        )
    )

procedure(port3(cv)
    let((port_master port3)
        port_master = dbOpenCellViewByType("analogLib" "port" "symbol" "" "r")
        schCreateInst(
            cv
            port_master
            "PORT3"
            4:1.5
            "R0"
            )
        Createwire(cv list(4:1.5 4:1.75))
        Createwire(cv list(4:0.75 4:1))
        schCreateWireLabel(
            cv
            nil
            4:1.75
            "outp"
            "centerCenter"
            "R90"
            "stick"
            0.0625
            nil
            )
        schCreateWireLabel(
            cv
            nil
            4:0.75
            "outm"
            "centerCenter"
            "R90"
            "stick"
            0.0625
            nil
            )
        port3 = car(setof(inst cv~>instances inst~>name == "PORT3"))
        dbReplaceProp(port3 "r" "string" "ZLoad_real")
        dbReplaceProp(port3 "x" "string" "ZLoad_imag")
        schCheck(cv)
        dbSave(cv)
        dbClose(cv)
        )
    )
